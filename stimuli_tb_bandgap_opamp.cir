**************************************
* SPICE STIMULI FILE
* generated from
**************************************

Vvss vss 0 PWL 0n 0
Ven_n en_n 0 PWL 0n 'VCC' 100n 'VCC' 101n 0
Vminus minus 0 PWL 0n 0.6 501n 0.6 502n 0.601 1000n 0.601 1001n 0.6 1501n
+0.6 1502n 0.599
Vstart start 0 PWL 0n 0 500n 0 501n 'VCC' 1000n 'VCC' 1001n 0 1500n
+0 1501n 'VCC'
Vvcc vcc 0 PWL 0n 'VCC'
Vplus plus 0 PWL 0n 0.6
